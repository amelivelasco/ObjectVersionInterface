*Custom Compiler Version T-2022.06-SP1
*Wed Aug  5 10:12:41 2026

*.SCALE METER
*.LDD
.GLOBAL GND!
********************************************************************************
* Library          : LayoutDone
* Cell             : VFHalf
* View             : flat
* View Search List : auCdl schematic
* View Stop List   : auCdl
********************************************************************************
.subckt VFHalf ControlRD D0 D0_bar D1 D1_bar D2 D2_bar Src26 net2 net3 net14
*.PININFO ControlRD:I D0:I D0_bar:I D1:I D1_bar:I D2:I D2_bar:I Src26:I net2:O
*.PININFO net3:O net14:O
XsjI122|X316 I122|net2 GND! jj_s ics=150u
XsjI122|X317 I122|net3 GND! jj_s ics=225u
XsjI122|X318 D0 I122|net5 jj_s ics=200u
XsjI124|X316 I124|net2 GND! jj_s ics=150u
XsjI124|X317 I124|net3 GND! jj_s ics=225u
XsjI124|X318 ControlRD I124|net5 jj_s ics=200u
XsjI123|X316 I123|net2 GND! jj_s ics=150u
XsjI123|X317 I123|net3 GND! jj_s ics=225u
XsjI123|X318 D0_bar I123|net5 jj_s ics=200u
XsjI121|X316 I121|net2 GND! jj_s ics=150u
XsjI121|X317 I121|net3 GND! jj_s ics=225u
XsjI121|X318 D1 I121|net5 jj_s ics=200u
XsjI120|X316 I120|net2 GND! jj_s ics=150u
XsjI120|X317 I120|net3 GND! jj_s ics=225u
XsjI120|X318 D1_bar I120|net5 jj_s ics=200u
XsjI118|X316 I118|net2 GND! jj_s ics=150u
XsjI118|X317 I118|net3 GND! jj_s ics=225u
XsjI118|X318 D2_bar I118|net5 jj_s ics=200u
XsjI119|X316 I119|net2 GND! jj_s ics=150u
XsjI119|X317 I119|net3 GND! jj_s ics=225u
XsjI119|X318 D2 I119|net5 jj_s ics=200u
XsjX408 net13 GND! jj_s ics=430u
XsjI117|X405 I117|net4 GND! jj_s ics=250u
XsjI117|X410 I117|net6 GND! jj_s ics=250u
XsjI117|X411 I117|net3 GND! jj_s ics=250u
XsjI104|I23|J5 I104|I23|net141 I104|I23|net142 jj_s ics=180u
XsjI104|I23|J1 I104|I23|net4 GND! jj_s ics=250u
XsjI104|I23|J2 I104|I23|net136 I104|I23|net140 jj_s ics=180u
XsjI104|I23|J4 I104|I23|net119 GND! jj_s ics=250u
XsjI104|I23|J7 I104|I23|net138 I104|I23|net121 jj_s ics=90u
XsjI104|I23|J10 I104|I23|net144 I104|I23|net124 jj_s ics=177u
XsjI104|I23|J3 I104|I23|net137 GND! jj_s ics=201u
XsjI104|I23|J6 I104|I23|net127 GND! jj_s ics=258u
XsjI104|I23|J8 I104|I23|net145 GND! jj_s ics=230u
XsjI104|I23|J11 I104|I23|net139 GND! jj_s ics=150u
XsjI104|I23|J9 I104|I23|net110 GND! jj_s ics=250u
XsjI104|X100 I104|net11 GND! jj_s ics=205u
XsjI104|X101 I104|net9 GND! jj_s ics=300u
XsjI104|X5 I104|net35 GND! jj_s ics=205u
XsjI104|X4 I104|net33 GND! jj_s ics=300u
XsjI104|X1 I104|net28 GND! jj_s ics=300u
XsjI104|X0 I104|net30 GND! jj_s ics=200u
XsjI104|X82 I104|net4 GND! jj_s ics=200u
XsjI104|X83 I104|net2 GND! jj_s ics=300u
XsjI106|I23|J5 I106|I23|net141 I106|I23|net142 jj_s ics=180u
XsjI106|I23|J1 I106|I23|net4 GND! jj_s ics=250u
XsjI106|I23|J2 I106|I23|net136 I106|I23|net140 jj_s ics=180u
XsjI106|I23|J4 I106|I23|net119 GND! jj_s ics=250u
XsjI106|I23|J7 I106|I23|net138 I106|I23|net121 jj_s ics=90u
XsjI106|I23|J10 I106|I23|net144 I106|I23|net124 jj_s ics=177u
XsjI106|I23|J3 I106|I23|net137 GND! jj_s ics=201u
XsjI106|I23|J6 I106|I23|net127 GND! jj_s ics=258u
XsjI106|I23|J8 I106|I23|net145 GND! jj_s ics=230u
XsjI106|I23|J11 I106|I23|net139 GND! jj_s ics=150u
XsjI106|I23|J9 I106|I23|net110 GND! jj_s ics=250u
XsjI106|X100 I106|net11 GND! jj_s ics=205u
XsjI106|X101 I106|net9 GND! jj_s ics=300u
XsjI106|X5 I106|net35 GND! jj_s ics=205u
XsjI106|X4 I106|net33 GND! jj_s ics=300u
XsjI106|X1 I106|net28 GND! jj_s ics=300u
XsjI106|X0 I106|net30 GND! jj_s ics=200u
XsjI106|X82 I106|net4 GND! jj_s ics=200u
XsjI106|X83 I106|net2 GND! jj_s ics=300u
XsjI105|I23|J5 I105|I23|net141 I105|I23|net142 jj_s ics=180u
XsjI105|I23|J1 I105|I23|net4 GND! jj_s ics=250u
XsjI105|I23|J2 I105|I23|net136 I105|I23|net140 jj_s ics=180u
XsjI105|I23|J4 I105|I23|net119 GND! jj_s ics=250u
XsjI105|I23|J7 I105|I23|net138 I105|I23|net121 jj_s ics=90u
XsjI105|I23|J10 I105|I23|net144 I105|I23|net124 jj_s ics=177u
XsjI105|I23|J3 I105|I23|net137 GND! jj_s ics=201u
XsjI105|I23|J6 I105|I23|net127 GND! jj_s ics=258u
XsjI105|I23|J8 I105|I23|net145 GND! jj_s ics=230u
XsjI105|I23|J11 I105|I23|net139 GND! jj_s ics=150u
XsjI105|I23|J9 I105|I23|net110 GND! jj_s ics=250u
XsjI105|X100 I105|net11 GND! jj_s ics=205u
XsjI105|X101 I105|net9 GND! jj_s ics=300u
XsjI105|X5 I105|net35 GND! jj_s ics=205u
XsjI105|X4 I105|net33 GND! jj_s ics=300u
XsjI105|X1 I105|net28 GND! jj_s ics=300u
XsjI105|X0 I105|net30 GND! jj_s ics=200u
XsjI105|X82 I105|net4 GND! jj_s ics=200u
XsjI105|X83 I105|net2 GND! jj_s ics=300u
LI122|L318 I122|net3 I122|net2 ind2 l=4.14p
LI122|L384 I122|net2 net9 ind2 l=3.8p
LI122|L320 I122|net4 I122|net3 ind2 l=1.06p
LI122|L321 D0 GND! ind2 l=2.15p
LI122|L322 I122|net5 I122|net4 ind2 l=1.06p
LI124|L318 I124|net3 I124|net2 ind2 l=4.14p
LI124|L384 I124|net2 net13 ind2 l=3.8p
LI124|L320 I124|net4 I124|net3 ind2 l=1.06p
LI124|L321 ControlRD GND! ind2 l=2.15p
LI124|L322 I124|net5 I124|net4 ind2 l=1.06p
LI123|L318 I123|net3 I123|net2 ind2 l=4.14p
LI123|L384 I123|net2 net8 ind2 l=3.8p
LI123|L320 I123|net4 I123|net3 ind2 l=1.06p
LI123|L321 D0_bar GND! ind2 l=2.15p
LI123|L322 I123|net5 I123|net4 ind2 l=1.06p
LI121|L318 I121|net3 I121|net2 ind2 l=4.14p
LI121|L384 I121|net2 net6 ind2 l=3.8p
LI121|L320 I121|net4 I121|net3 ind2 l=1.06p
LI121|L321 D1 GND! ind2 l=2.15p
LI121|L322 I121|net5 I121|net4 ind2 l=1.06p
LI120|L318 I120|net3 I120|net2 ind2 l=4.14p
LI120|L384 I120|net2 net5 ind2 l=3.8p
LI120|L320 I120|net4 I120|net3 ind2 l=1.06p
LI120|L321 D1_bar GND! ind2 l=2.15p
LI120|L322 I120|net5 I120|net4 ind2 l=1.06p
LI118|L318 I118|net3 I118|net2 ind2 l=4.14p
LI118|L384 I118|net2 net11 ind2 l=3.8p
LI118|L320 I118|net4 I118|net3 ind2 l=1.06p
LI118|L321 D2_bar GND! ind2 l=2.15p
LI118|L322 I118|net5 I118|net4 ind2 l=1.06p
LI119|L318 I119|net3 I119|net2 ind2 l=4.14p
LI119|L384 I119|net2 net12 ind2 l=3.8p
LI119|L320 I119|net4 I119|net3 ind2 l=1.06p
LI119|L321 D2 GND! ind2 l=2.15p
LI119|L322 I119|net5 I119|net4 ind2 l=1.06p
LI117|L411 I117|net7 I117|net3 ind2 l=1.7p
LI117|L406 I117|net7 I117|net4 ind2 l=1.7p
LI117|L111 I117|net4 I117|net10 ind2 l=9p
LI117|L112 I117|net10 net7 ind2 l=12p
LI117|L408 net13 I117|net7 ind2 l=4p
LI117|L410 I117|net7 I117|net6 ind2 l=8p
LI117|L109 I117|net3 I117|net9 ind2 l=9p
LI117|L110 I117|net9 net10 ind2 l=12p
LI117|L3 I117|net6 net4 ind2 l=20p
LI104|I23|L1 I104|net8 I104|I23|net4 ind2 l=3.7p
LI104|I23|L2 I104|I23|net4 I104|I23|net136 ind2 l=3.1p
LI104|I23|L3 I104|I23|net137 I104|I23|net138 ind2 l=5.6p
LI104|I23|L4 I104|net7 I104|I23|net119 ind2 l=3.4p
LI104|I23|L5 I104|I23|net119 I104|I23|net141 ind2 l=3.4p
LI104|I23|L6 I104|I23|net127 I104|I23|net138 ind2 l=7.2p
LI104|I23|L7 I104|I23|net121 I104|I23|net100 ind2 l=2.7p
LI104|I23|L8 I104|I23|net100 I104|I23|net145 ind2 l=4.2p
LI104|I23|L9 I104|net6 I104|I23|net110 ind2 l=2.7p
LI104|I23|L10 I104|I23|net110 I104|I23|net124 ind2 l=5.5p
LI104|I23|L11 I104|I23|net145 I104|I23|net139 ind2 l=6.7p
LI104|I23|L12 I104|I23|net139 I104|net5 ind2 l=2.4p
LI104|I23|L74 I104|I23|net140 I104|I23|net137 ind2 l=3.1p
LI104|I23|L76 I104|I23|net144 I104|I23|net145 ind2 l=1p
LI104|I23|L75 I104|I23|net142 I104|I23|net127 ind2 l=2p
LI104|L101 I104|net11 I104|net10 ind2 l=1.1p
LI104|L100 I104|net10 I104|net9 ind2 l=1.2p
LI104|L102 I104|net9 I104|net6 ind2 l=3.8p
LI104|L103 net10 I104|net11 ind2 l=2p
LI104|L23 I104|net34 I104|net33 ind2 l=0.6p
LI104|L22 I104|net35 I104|net34 ind2 l=1.7p
LI104|L20 I104|net30 I104|net29 ind2 l=1.1p
LI104|L15 I104|net33 I104|net8 ind2 l=4p
LI104|L11 net11 I104|net30 ind2 l=2p
LI104|L14 net12 I104|net35 ind2 l=2p
LI104|L10 I104|net28 I104|net7 ind2 l=3.8p
LI104|L21 I104|net29 I104|net28 ind2 l=1.2p
LI104|L80 I104|net3 I104|net2 ind2 l=1.05p
LI104|L71 I104|net4 I104|net3 ind2 l=1.05p
LI104|L81 I104|net2 net3 ind2 l=1.05p
LI104|L73 I104|net5 I104|net4 ind2 l=2.75p
LI106|I23|L1 I106|net8 I106|I23|net4 ind2 l=3.7p
LI106|I23|L2 I106|I23|net4 I106|I23|net136 ind2 l=3.1p
LI106|I23|L3 I106|I23|net137 I106|I23|net138 ind2 l=5.6p
LI106|I23|L4 I106|net7 I106|I23|net119 ind2 l=3.4p
LI106|I23|L5 I106|I23|net119 I106|I23|net141 ind2 l=3.4p
LI106|I23|L6 I106|I23|net127 I106|I23|net138 ind2 l=7.2p
LI106|I23|L7 I106|I23|net121 I106|I23|net100 ind2 l=2.7p
LI106|I23|L8 I106|I23|net100 I106|I23|net145 ind2 l=4.2p
LI106|I23|L9 I106|net6 I106|I23|net110 ind2 l=2.7p
LI106|I23|L10 I106|I23|net110 I106|I23|net124 ind2 l=5.5p
LI106|I23|L11 I106|I23|net145 I106|I23|net139 ind2 l=6.7p
LI106|I23|L12 I106|I23|net139 I106|net5 ind2 l=2.4p
LI106|I23|L74 I106|I23|net140 I106|I23|net137 ind2 l=3.1p
LI106|I23|L76 I106|I23|net144 I106|I23|net145 ind2 l=1p
LI106|I23|L75 I106|I23|net142 I106|I23|net127 ind2 l=2p
LI106|L101 I106|net11 I106|net10 ind2 l=1.1p
LI106|L100 I106|net10 I106|net9 ind2 l=1.2p
LI106|L102 I106|net9 I106|net6 ind2 l=3.8p
LI106|L103 net4 I106|net11 ind2 l=2p
LI106|L23 I106|net34 I106|net33 ind2 l=0.6p
LI106|L22 I106|net35 I106|net34 ind2 l=1.7p
LI106|L20 I106|net30 I106|net29 ind2 l=1.1p
LI106|L15 I106|net33 I106|net8 ind2 l=4p
LI106|L11 net5 I106|net30 ind2 l=2p
LI106|L14 net6 I106|net35 ind2 l=2p
LI106|L10 I106|net28 I106|net7 ind2 l=3.8p
LI106|L21 I106|net29 I106|net28 ind2 l=1.2p
LI106|L80 I106|net3 I106|net2 ind2 l=1.05p
LI106|L71 I106|net4 I106|net3 ind2 l=1.05p
LI106|L81 I106|net2 net2 ind2 l=1.05p
LI106|L73 I106|net5 I106|net4 ind2 l=2.75p
LI105|I23|L1 I105|net8 I105|I23|net4 ind2 l=3.7p
LI105|I23|L2 I105|I23|net4 I105|I23|net136 ind2 l=3.1p
LI105|I23|L3 I105|I23|net137 I105|I23|net138 ind2 l=5.6p
LI105|I23|L4 I105|net7 I105|I23|net119 ind2 l=3.4p
LI105|I23|L5 I105|I23|net119 I105|I23|net141 ind2 l=3.4p
LI105|I23|L6 I105|I23|net127 I105|I23|net138 ind2 l=7.2p
LI105|I23|L7 I105|I23|net121 I105|I23|net100 ind2 l=2.7p
LI105|I23|L8 I105|I23|net100 I105|I23|net145 ind2 l=4.2p
LI105|I23|L9 I105|net6 I105|I23|net110 ind2 l=2.7p
LI105|I23|L10 I105|I23|net110 I105|I23|net124 ind2 l=5.5p
LI105|I23|L11 I105|I23|net145 I105|I23|net139 ind2 l=6.7p
LI105|I23|L12 I105|I23|net139 I105|net5 ind2 l=2.4p
LI105|I23|L74 I105|I23|net140 I105|I23|net137 ind2 l=3.1p
LI105|I23|L76 I105|I23|net144 I105|I23|net145 ind2 l=1p
LI105|I23|L75 I105|I23|net142 I105|I23|net127 ind2 l=2p
LI105|L101 I105|net11 I105|net10 ind2 l=1.1p
LI105|L100 I105|net10 I105|net9 ind2 l=1.2p
LI105|L102 I105|net9 I105|net6 ind2 l=3.8p
LI105|L103 net7 I105|net11 ind2 l=2p
LI105|L23 I105|net34 I105|net33 ind2 l=0.6p
LI105|L22 I105|net35 I105|net34 ind2 l=1.7p
LI105|L20 I105|net30 I105|net29 ind2 l=1.1p
LI105|L15 I105|net33 I105|net8 ind2 l=4p
LI105|L11 net8 I105|net30 ind2 l=2p
LI105|L14 net9 I105|net35 ind2 l=2p
LI105|L10 I105|net28 I105|net7 ind2 l=3.8p
LI105|L21 I105|net29 I105|net28 ind2 l=1.2p
LI105|L80 I105|net3 I105|net2 ind2 l=1.05p
LI105|L71 I105|net4 I105|net3 ind2 l=1.05p
LI105|L81 I105|net2 net14 ind2 l=1.05p
LI105|L73 I105|net5 I105|net4 ind2 l=2.75p
XpcI104|IB1 GND! Src26 I104|net10 pwrcell ib=280u
XpcI104|IB3 GND! Src26 I104|net34 pwrcell ib=280u
XpcI104|IB4 GND! Src26 I104|net3 pwrcell ib=250u
XpcI104|IB2 GND! Src26 I104|net29 pwrcell ib=280u
XpcI104|I23|IB1 GND! Src26 I104|I23|net4 pwrcell ib=175u
XpcI104|I23|IB2 GND! Src26 I104|I23|net137 pwrcell ib=139u
XpcI104|I23|IB3 GND! Src26 I104|I23|net119 pwrcell ib=175u
XpcI104|I23|IB4 GND! Src26 I104|I23|net100 pwrcell ib=158u
XpcI104|I23|IB6 GND! Src26 I104|I23|net139 pwrcell ib=175u
XpcI104|I23|IB5 GND! Src26 I104|I23|net110 pwrcell ib=175u
XpcI106|IB1 GND! Src26 I106|net10 pwrcell ib=280u
XpcI106|IB3 GND! Src26 I106|net34 pwrcell ib=280u
XpcI106|IB4 GND! Src26 I106|net3 pwrcell ib=250u
XpcI106|IB2 GND! Src26 I106|net29 pwrcell ib=280u
XpcI106|I23|IB1 GND! Src26 I106|I23|net4 pwrcell ib=175u
XpcI106|I23|IB2 GND! Src26 I106|I23|net137 pwrcell ib=139u
XpcI106|I23|IB3 GND! Src26 I106|I23|net119 pwrcell ib=175u
XpcI106|I23|IB4 GND! Src26 I106|I23|net100 pwrcell ib=158u
XpcI106|I23|IB6 GND! Src26 I106|I23|net139 pwrcell ib=175u
XpcI106|I23|IB5 GND! Src26 I106|I23|net110 pwrcell ib=175u
XpcI105|IB1 GND! Src26 I105|net10 pwrcell ib=280u
XpcI105|IB3 GND! Src26 I105|net34 pwrcell ib=280u
XpcI105|IB4 GND! Src26 I105|net3 pwrcell ib=250u
XpcI105|IB2 GND! Src26 I105|net29 pwrcell ib=280u
XpcI105|I23|IB1 GND! Src26 I105|I23|net4 pwrcell ib=175u
XpcI105|I23|IB2 GND! Src26 I105|I23|net137 pwrcell ib=139u
XpcI105|I23|IB3 GND! Src26 I105|I23|net119 pwrcell ib=175u
XpcI105|I23|IB4 GND! Src26 I105|I23|net100 pwrcell ib=158u
XpcI105|I23|IB6 GND! Src26 I105|I23|net139 pwrcell ib=175u
XpcI105|I23|IB5 GND! Src26 I105|I23|net110 pwrcell ib=175u
RI122|R315 Src26 I122|net4 res r='2.6e-3/275e-6'
RI122|R316 Src26 I122|net2 res r='2.6e-3/175e-6'
RI124|R315 Src26 I124|net4 res r='2.6e-3/275e-6'
RI124|R316 Src26 I124|net2 res r='2.6e-3/175e-6'
RI123|R315 Src26 I123|net4 res r='2.6e-3/275e-6'
RI123|R316 Src26 I123|net2 res r='2.6e-3/175e-6'
RI121|R315 Src26 I121|net4 res r='2.6e-3/275e-6'
RI121|R316 Src26 I121|net2 res r='2.6e-3/175e-6'
RI120|R315 Src26 I120|net4 res r='2.6e-3/275e-6'
RI120|R316 Src26 I120|net2 res r='2.6e-3/175e-6'
RI118|R315 Src26 I118|net4 res r='2.6e-3/275e-6'
RI118|R316 Src26 I118|net2 res r='2.6e-3/175e-6'
RI119|R315 Src26 I119|net4 res r='2.6e-3/275e-6'
RI119|R316 Src26 I119|net2 res r='2.6e-3/175e-6'
RI117|R116 Src26 I117|net7 res r='2.6e-3/1m'
.ends VFHalf
