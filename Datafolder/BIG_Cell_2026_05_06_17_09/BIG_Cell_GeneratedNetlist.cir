*.LDD
.GLOBAL GND!
********************************************************************************
* Library          : BasicCellsHomemade
* Cell             : SFQtoCMOSNo_par_res
* View             : schematic
* View Search List : auCdl schematic
* View Stop List   : auCdl
********************************************************************************
.subckt SFQtoCMOSNo_par_res net10 net7 VDD
*.PININFO DC:O SFQ_in:I VDD:I
*LL1 net7 net6
*LL2 net3 net8
*LL3 net9 net3
*LL4 net10 net8
*LL5 net9 net4
*LL6 net11 net12
*LL7 net12 net13
*LL8 net14 net15
*LL9 net2 net16
*LL10 net15 net17
*LL11 net13 net15
*LL12 net16 net13
*LL13 net5 net16
*LL14 net6 net18
*LL15 net19 net6
*RR1 net11 GND!
